# Ansys Electronics Desktop project, version 2020.1
materials:
  vacuum: permittivity=1
  aluminum6061: permeability=1.000021 conductivity=25000000
  Steel_wear_resistant: permeability=1.000021 conductivity=2200000
  steel_1008: permeability{HUnit=A_per_meter BUnit=tesla curve } conductivity=2000000
  copper: permeability=0.999991 conductivity=58000000
  solder: permeability=2000 conductivity=7000000

design Maxwell3DDesign1 (Maxwell 3D, Transient, model units mm)
variables:
  s = 0mm
datasets:
  ds1:
  ds2: (0, 0) (1e-05, 10369.873) (2e-05, 18560.79) (3e-05, 27478.03) (4e-05, 43945.32) (5e-05, 55889.95) (6e-05, 65771.45) (7e-05, 75647.07) (8e-05, 92865) (9e-05, 96105.9) (0.0001, 117095.8) (0.00011, 115509) (0.00012, 126867.7) (0.00013, 133844) (0.00014, 139349.3) (0.00015, 154351.7) (0.00016, 153033.4) (0.00017, 166143.8) (0.00018, 166088.9) (0.00019, 172406) (0.0002, 176324.4) (0.00021, 174108.8) (0.00022, 185412.6) (0.00023, 184277.3) (0.00024, 196087.6) (0.00025, 191345.2) (0.00026, 182891.9) (0.00027, 195843.6) (0.00028, 184039.3) (0.00029, 190844.8) (0.0003, 184185.8) (0.00031, 188281.2) (0.00032, 187554.9) (0.00033, 188610.9) (0.00034, 185211.2) (0.00035, 175012.3) (0.00036, 183093.3) (0.00037, 171630.8) (0.00038, 183612.1) (0.00039, 176971.5) (0.0004, 181671.2) (0.00041, 181701.7) (0.00042, 172711.3) (0.00043, 178942.9) (0.00044, 167968.7) (0.00045, 177325.4) (0.00046, 175836.2) (0.00047, 178216.6) (0.00048, 178540) (0.00049, 175451.6) (0.0005, 176257.3) (0.00051, 168811) (0.00052, 173669.5) (0.00053, 165142.7) (0.00054, 173522.9) (0.00055, 177825.8) (0.00056, 172460.9) (0.00057, 178686.5) (0.00058, 171698) (0.00059, 176611.3) (0.0006, 175671.3) (0.00061, 167230.3) (0.00062, 171154.8) (0.00063, 168792.8) (0.00064, 178546.1) (0.00065, 167047.1) (0.00066, 176532.1) (0.00067, 163696.3) (0.00068, 165985.1) (0.00069, 164117.5) (0.0007, 159881.5) (0.00071, 177423.2) (0.00072, 164202.8) (0.00073, 170892.2) (0.00074, 160760.4) (0.00075, 166192.7) (0.00076, 159942.7) (0.00077, 160479.7) (0.00078, 158184.8) (0.00079, 159442.2) (0.0008, 161706.5) (0.00081, 159350.7) (0.00082, 156951.9) (0.00083, 155425.9) (0.00084, 152746.6) (0.00085, 154516.6) (0.00086, 153094.5) (0.00087, 153735.4) (0.00088, 154943.8) (0.00089, 147778.3) (0.0009, 153595.1) (0.00091, 147845.6) (0.00092, 150317.3) (0.00093, 145050.1) (0.00094, 149102.8) (0.00095, 149426.3) (0.00096, 149646) (0.00097, 148950.2) (0.00098, 145953.3) (0.00099, 147705.1) (0.001, 141192.6) (0.00101, 144470.2) (0.00102, 143438.7) (0.00103, 145294.1) (0.00104, 144769.3) (0.00105, 144977) (0.00106, 145001.3) (0.00107, 140710.4) (0.00108, 141229.3) (0.00109, 138348.5) (0.0011, 140350.3) (0.00111, 142956.6) (0.00112, 140899.7) (0.00113, 141131.6) (0.00114, 140850.7) (0.00115, 137017.8) (0.00116, 141302.4) (0.00117, 135308.8) (0.00118, 146282.8) (0.00119, 136724.9)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
geometry:
  arma = imported_body(F:\DCJR_LAB\lab-2200mm.IGS)
  layer [Steel_wear_resistant] = imported_body(F:\DCJR_LAB\lab-2200mm.IGS)
  layer.move(0mm, 0mm, -25mm)
  Armature [aluminum6061] = box(corner=(0mm, -15mm, -40mm), size=(20mm, 30mm, 80mm))
  Armature.intersect(arma)
  Box1_1 = Armature.duplicate_mirror(point=(0mm, 10mm, -15mm), normal=(1mm, 0mm, 0mm))
  Armature.unite(Box1_1)
  Armature.rotate(axis=X, angle=180deg)
  Armature.move(0mm, 10mm, 15mm)
  Armature.move(0mm, 0mm, 100mm)
  rail_m1 [copper] = box(corner=(12mm, -10mm, 0mm), size=(6mm, 30mm, 200mm))
  [layer, Armature, rail_m1].move(0mm, -5mm, 0mm)
  Armature.move(0mm, 0mm, s)
  Region [vacuum] = region(transverse_percentage_offset: +X=10, -X=0, +Y=0.5, -Y=0.5, +Z=1, -Z=0)
  Box3 = box(corner=(-9.1261365mm, -5mm, 100mm), size=(18.252273mm, 10mm, 7.5mm))
  Armature.subtract(Box3)
  Box4 = box(corner=(-3.3424637mm, -5mm, 107.5mm), size=(3.3424637mm, 10mm, 15mm))
  Box5 = box(corner=(60mm, -20mm, 2220mm), size=(-88mm, 40mm, -2020mm))
  Box5_1 = Box5.copy()
  Box5.delete()
  layer.subtract(Box5_1)
  Box6 = box(corner=(0mm, -5mm, 107.5mm), size=(3.3424637mm, 10mm, 15mm))
  Armature.subtract(Box4, Box6)
  Box7 = box(corner=(-9.1261365mm, 5mm, 107.5mm), size=(18.252273mm, -10mm, 4mm))
  Armature.subtract(Box7)
  Box8 = box(corner=(3.3424637mm, -5mm, 122.5mm), size=(-2.5mm, 10mm, -2.5mm))
  Cylinder1 = cylinder(axis=Y, base_centre=(2.0924637mm, -5mm, 121.25mm), radius=1.25mm, height=10mm)
  Box9 = box(corner=(-3.3424637mm, -5mm, 122.5mm), size=(2.5mm, 10mm, -2.5mm))
  Cylinder2 = cylinder(axis=Y, base_centre=(-2.0924637mm, -5mm, 121.25mm), radius=1.25mm, height=10mm)
  Box8.subtract(Cylinder1)
  Box9.subtract(Cylinder2)
  Box10 = box(corner=(3.3424637mm, -5mm, 121.25mm), size=(-3.3424637mm, 10mm, -1.25mm))
  Box8.subtract(Box10)
  Box11 = box(corner=(-0.84246366mm, -5mm, 121.25mm), size=(-2.5mm, 10mm, -1.25mm))
  Box9.subtract(Box11)
  Box12 = box(corner=(2.0924637mm, -5mm, 122.5mm), size=(-2.0924637mm, 10mm, -2.5mm))
  Box13 = box(corner=(-2.0924637mm, -5mm, 122.5mm), size=(2.0924637mm, 10mm, -2.5mm))
  Box8.subtract(Box12)
  Box9.subtract(Box13)
  Armature.unite(Box8, Box9)
  Box14 = box(corner=(0mm, -20mm, 200mm), size=(-20mm, 40mm, -200mm))
  Box14_1 = Box14.copy()
  Armature.subtract(Box14_1)
  Box14_2 = Box14.copy()
  layer.subtract(Box14_2)
  Box14_4 = Box14.copy()
  Box14.delete()
  rail_m1.subtract(Box14_4)
  point Point1 = (0mm, 7.5mm, 0mm)
  point Point2 = (1.03mm, 7.39mm, 0mm)
  point Point3 = (1.81mm, 8.03mm, 0mm)
  point Point4 = (1.85mm, 10mm, 0mm)
  point Point5 = (3.75mm, 10mm, 0mm)
  point Point6 = (4.0238924mm, 0mm, 130mm)
boundaries and excitations:
  Insulating1: Insulating Faces=rail_m1.face(+z)
  CoilTerminal_1: Coil Terminal Faces=rail_m1.face(-z) Conductor_number=1 Winding=Winding1 Point_out_of_terminal=false
  CoilTerminal1: Coil Terminal Faces=Armature.face(at (0, 0, 126.25)) Conductor_number=1 Winding=Winding1 Point_out_of_terminal=true
  Winding1: Winding Group Type=Current IsSolid=true Current=pwlx(ds2,time) ParallelBranchesNum=1
  eddy effects on: layer, Armature, rail_m1
mesh:
  Length1: LengthBased RefineInside Objects=Armature MaxLength=2mm
  Length2: LengthBased RefineInside Objects=layer MaxLength=5mm
  Length3: LengthBased RefineInside Objects=rail_m1 MaxLength=15mm
  Length4: LengthBased RefineInside Objects=[layer, Armature, rail_m1, Region] MaxLength=50mm
  initial mesh: GlobalCurvilinear{Apply}
setups:
  Setup1: Transient NonlinearSolverResidual=0.005 ScalarPotential="Second Order" StopTime=4ms TimeStep=0.02ms SaveFieldsType="Every N Steps" N_Steps=1 Steps_From=0s Steps_To=2ms NumberSolveSteps=1 RangeStart=0s RangeEnd=0.1s
field plots:
  Mesh2: MeshPlots in Armature on Setup1 : Transient at Time=0ns
  Mag_B1, Mag_B2: B over Armature.face(at (0, 0, 126.25)) on Setup1 : Transient at Time=0ns
  Mesh1: MeshPlots over Armature.face(at (0, 0, 126.25)) on Setup1 : Transient at Time=0ns
reports:
  Calculator Expressions Table 1: Mag_B, Mag_B, Mag_B, Mag_B, Mag_B, Mag_B vs Time on Setup1 : Transient
